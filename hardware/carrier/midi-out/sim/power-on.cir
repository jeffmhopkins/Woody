* Power-on: both rails up, IO6 and IO2 high-impedance after their power-up glitch.
* Each pad is driven low from t = 0 for g_t / g_r (the glitch), through the pad's own
* resistance, then released; R-MIDI-PU pulls each input to DEV_3V3 against a worst-case
* weak pull-down on the pad. The gates' inputs are a threshold (behavioural); a Type A
* receiver at the far end of the cable.
V3 d3 0 {{dev_3v3}}
RPT d3 in_t {{R-MIDI-PU}}
RPR d3 in_r {{R-MIDI-PU}}
RDT in_t 0 {{r_pd}}
RDR in_r 0 {{r_pd}}
CIT in_t 0 {{c_in}}
CIR in_r 0 {{c_in}}
VGT gtc 0 PULSE(1 0 {{g_t}} 10n 10n 1 2)
VGR grc 0 PULSE(1 0 {{g_r}} 10n 10n 1 2)
ST in_t 0 gtc 0 SPAD
SR in_r 0 grc 0 SPAD
.model SPAD SW(VT=0.5 VH=0 RON={{r_pad}} ROFF=1e12)
BCT ct 0 V=0.5-0.5*tanh((V(in_t)-{{vth}})/0.05)
BCR cr 0 V=0.5-0.5*tanh((V(in_r)-{{vth}})/0.05)
XGT ct gt MGATE
XGR cr gr MGATE
XLT gt tip MLINE
XLR gr ring MLINE
XC tip ring tipf ringf MCABLE
VS ringf p4 0
XRX p4 tipf led MRX
.control
tran 20n {{t_end_pon}} 0 20n
wrdata i.dat i(vs)
wrdata int.dat v(in_t)
wrdata inr.dat v(in_r)
quit
.endc
.end
