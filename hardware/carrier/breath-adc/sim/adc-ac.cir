* The anti-alias filter as netlisted, small-signal: R-ADCDIV-U from the buffered sensor
* output, R-ADCDIV-L and C-AA-ADC at ADC_IN. The sample switch is open (it is closed for
* under 1 % of the loop period).
VSRC src 0 DC 0 AC 1
RU src adc {{R-ADCDIV-U}}
RL adc 0 {{R-ADCDIV-L}}
CAA adc 0 {{C-AA-ADC}}
.control
ac dec 200 1 10meg
let hdb = db(v(adc))
wrdata hdb.dat hdb
quit
.endc
.end
