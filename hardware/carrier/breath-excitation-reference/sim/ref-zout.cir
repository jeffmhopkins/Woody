* |Z_out| at VS, closed loop, as netlisted: a 1 A AC test current into VS, so |V(VS)| is
* the impedance. The page's claim is about 500 Hz, the breath channel's edge.
VPOS pos 0 {{v_pos}}
* the REF5050 is outside this loop: its VOUT feeds only U-BUF's (+) input, which draws pA,
* and C-REF-OUT holds it. It is a 5.000 V source here, on its netlisted capacitors; its own
* macromodel runs in ref-startup.cir (inside one deck with the buffer its operating point
* is not unique - it settles, corner by corner, on a collapsed state with VIN at 35 mV)
VREFI refsrc 0 {{v_ref}}
RREFO refsrc ref5v {{r_ref_out}}
CROUT ref5v crn {{C-REF-OUT-VOUT}}
RCROUT crn 0 {{esr_cref}}
CDVOUT ref5v 0 {{C-DEC-REF-VOUT}}
XBUF ref5v refminus pos 0 bufout OPAx197
RFX bufout acmid {{R-FBX-REF}}
CF acmid refminus {{C-FB-REF}}
RF vs refminus {{R-FB-REF}}
RISO bufout vs {{R-ISO-REF}}
CL vs cln {{c_load}}
RCL cln 0 {{esr_cvs}}
ISENS vs 0 DC {{i_sensor}} AC 1
* rshunt: 10 Gohm from every node to ground, so the macromodel's operating point is found
* (without it, or at 1 Tohm, some corners found none); 0.5 nA at 5 V, a tenth of U-BUF's own
* guaranteed I_B, so 5 uV across R-FB-REF at most.
.options method=gear rshunt=1e10
.control
ac dec 50 10 10meg
let z = mag(v(vs))
wrdata zvs.dat z
quit
.endc
.end
