* The response shaper and this stage, one after the other, both as netlisted: the
* in-amp's output (EIN, -1 x VMAG) ramps from 0 V to its full scale in t_ramp, slow
* against the op-amps (a DC sweep loses TI's model where the output clips, as in
* breath-response-shaper/sim). The shaper is that circuit's deck verbatim: R-RESP-IN and
* the R-RESP-DIV pair, U-RESP half A at -R-RESP-FB/R-RESP-IN to V_SHAPED, POT-RESP from
* V_IN_HALF (CW) to V_SHAPED (CCW), its wiper through R-RESP, TRIM-RESP and the
* antiparallel D-RESP pair into the virtual ground, half B restoring at
* -R-RESTORE-FB/R-RESTORE-IN to BREATH_SHAPED. TRIM-RESP is commissioned as that
* circuit's deck does it when `trimmed` is 1 (POT-RESP fully clockwise, bisected until a
* hard blow gives g_trim at BREATH_SHAPED, at t_comm), or sits at r_trim when it is 0. Then this stage as bos.cir draws it: POT-GAIN, R-GAIN-FLOOR, the buffer,
* the summer with POT-OFFSET (AGND_MOD at CW, DAC_AVDD at CCW), R-OUT-PROT,
* C-OUT-BREATH and the load. D-RESP is the shaper sim's behavioural diode. The output
* measured is the op-amp's (BREATH_OUT): the jack is R-OUT-PROT's 1 % lower into
* 100 kohm, and C-OUT-BREATH would lag a ramp this fast.
VPOS pos 0 {{v_pos}}
VNEG neg 0 {{v_neg}}
VAVDD avdd 0 {{v_avdd}}
VMAG mag 0 PWL(0 0 {{t_ramp}} {{v_mag}})
EIN in 0 mag 0 -1
RDH in vhalf {{R-RESP-DIV-HI}}
RDL vhalf 0 {{R-RESP-DIV-LO}}
RRIN in vg {{R-RESP-IN}}
RRFB vg vsh {{R-RESP-FB}}
XSA 0 vg pos neg vsh OPAx197
RPCW vhalf wip {{r_pot_cw}}
RPCCW wip vsh {{r_pot_ccw}}
RRESP wip tr {{R-RESP}}
RTRIM tr db {{r_trim}}
DA vg db DRESP
DB db vg DRESP
RRI vsh rs {{R-RESTORE-IN}}
RRF rs shaped {{R-RESTORE-FB}}
XSB 0 rs pos neg shaped OPAx197
RGCW shaped gw {{r_gain_cw}}
RGCCW gw gf {{r_gain_ccw}}
RFLOOR gf 0 {{R-GAIN-FLOOR}}
XA gw bufo pos neg bufo OPAx197
RIN bufo sum {{R-BREATH-IN}}
ROCW 0 ow {{r_off_cw}}
ROCCW ow avdd {{r_off_ccw}}
ROFF ow sum {{R-BREATH-OFF}}
ROFFN neg sum {{R-BREATH-OFFNEG}}
RFB sum out {{R-BREATH-FB}}
XB 0 sum pos neg out OPAx197
ROUT out jack {{R-OUT-PROT}}
COUT jack 0 {{C-OUT-BREATH}}
RLOAD jack 0 {{r_load}}
.model DRESP D(IS={{is_d}} N={{n_d}} RS={{rs_d}} CJO=1.5p)
.options method=gear rshunt=1e10
.control
if {{trimmed}} > 0
  let tr_lo = {{r_trim_end}}
  let tr_hi = {{TRIM-RESP}}
  alter rpcw = 1e-3
  alter rpccw = {{POT-RESP}}
  option temp={{t_comm}}
  let k = 0
  while k < 12
    let mid = (tr_lo + tr_hi) / 2
    alter rtrim = mid
    tran 2u {{t_hard_c_run}} 0 4u
    meas tran vset find v(shaped) at={{t_hard_c}}
    let g_set = -vset / {{v_hard_mag}}
    if g_set > {{g_trim}}
      let tr_lo = mid
    else
      let tr_hi = mid
    end
    let k = k + 1
  end
  print g_set
  alter rpcw = {{r_pot_cw}}
  alter rpccw = {{r_pot_ccw}}
end
option temp={{temp_c}}
tran 2u {{t_ramp}} 0 4u
wrdata out.dat v(out)
wrdata shaped.dat v(shaped)
quit
.endc
.end
