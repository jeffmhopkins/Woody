* DAC_AVDD's set point across U-REG-DAC's (LT3042) datasheet limits - the owner's precision-set
* rail, 2026-10-01, which replaced the LM317L and its trimmer. DC, BEHAVIOURAL (lt3042.lib): the
* SET current (98-102 uA) and OUT - SET (+-2 mV) at their guaranteed limits over line, load and
* temperature [datasheets/discrete-and-power/ADI-LT3042.pdf p.3], R-SET-DAC's tolerance and drift,
* leakage at the SET node, the input from a tripped fuse to the bus maximum, and the rail's load.
* Faults: rset_fault 1 opens R-SET-DAC; 2 shorts C-SET-DAC (SET to ground).
VIN in 0 DC {{v_in_dac}}
XREG in avdd set 0 LT3042B
RSET set 0 {{r_set_eff}}
RCSH set 0 {{r_cset_eff}}
ILEAK set 0 DC {{i_leak}}
RLOAD avdd 0 {{r_dac_load}}
.options rshunt=1e10
.control
op
let v_avdd = v(avdd)
print v_avdd
quit
.endc
.end
