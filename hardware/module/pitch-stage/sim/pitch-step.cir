* The pitch stage, as netlisted (pitch-stage.lib), stepped - twice in one run: XA as built,
* with D-ESD-PITCH on its jack, and XB without it, on the same sources and the same load,
* so the clamp's effect is one subtraction (d_overshoot) rather than two runs compared.
* D-ESD-PITCH is its datasheet capacitance (c_esd) and its leakage at the 15 V standoff as
* a resistance (r_esd): inside +-15 V it does not conduct, and the jack never leaves +-12 V.
* The DAC is an ideal source with a t_edge edge: its settling is slower than that, so this
* is the harder step. The jack drives a VCO input (r_vco), the patch cable's capacitance
* (c_cable) and, on a passive mult, another output's jack: its C-FILT (c_mult) and, when
* r_mult is its R-OUT-PROT, its driver held at 0 V.
VPOS pos 0 {{v_pos}}
VNEG neg 0 {{v_neg}}
VREFO vrefout 0 {{v_refout}}
VDAC dacpin 0 PWL(0 {{v_dac0}} {{t_step}} {{v_dac0}} {{t_step_e}} {{v_dac1}})
RBD dacpin 0 {{R-BIAS-DAC}}
XA vrefout dacpin jack pos neg vrefba ma ma PSTAGE
CESD jack 0 {{c_esd}}
RESD jack 0 {{r_esd}}
CCABA jack 0 {{c_cable_f}}
CMULTA jack 0 {{c_mult}}
RVCOA jack 0 {{r_vco}}
RMULTA jack 0 {{r_mult}}
XB vrefout dacpin jackb pos neg vrefbb mb mb PSTAGE
CCABB jackb 0 {{c_cable_f}}
CMULTB jackb 0 {{c_mult}}
RVCOB jackb 0 {{r_vco}}
RMULTB jackb 0 {{r_mult}}
.options method=gear rshunt=1e10
.control
tran 100n {{t_end}} 0 100n
wrdata jack.dat v(jack)
wrdata jackb.dat v(jackb)
quit
.endc
.end
