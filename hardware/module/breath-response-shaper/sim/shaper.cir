* The response shaper, as netlisted: the in-amp's output (EIN, -1 x VMAG: the sweep runs
* from 0 V to the in-amp's full scale in t_ramp, slow against the op-amps: a transient
* ramp, because a DC sweep loses the macromodel's operating point where the output clips)
* into R-RESP-IN and the R-RESP-DIV pair; U-RESP half A inverting at -R-RESP-FB/R-RESP-IN
* to V_SHAPED; POT-RESP from V_IN_HALF (CW) to V_SHAPED (CCW), its wiper through R-RESP,
* TRIM-RESP (as the resistance between its strapped wiper and its CW end) and the
* antiparallel D-RESP pair into the virtual ground; half B restoring at
* -R-RESTORE-FB/R-RESTORE-IN to BREATH_SHAPED. TI's OPA2197 model for both halves.
* D-RESP is BEHAVIOURAL (no vendor model banked): a SPICE diode fitted to the banked
* datasheets' forward voltage (sims.yaml says which). POT-RESP is two resistors about its
* wiper; p_resp is its rotation from CCW (0, fully log) to CW (1, fully exp).
*
* THE COMMISSIONING STEP, when `trimmed` is 1: POT-RESP fully clockwise, at t_comm, the
* control block bisects TRIM-RESP between its end resistance and its whole track until a
* hard blow (the in-amp at v_hard) gives g_trim, as a builder turning the trimmer would;
* it prints the gain it reached (g_set) and the resistance (r_set). Then, at the sim's own
* p_resp: a short run at t_cold (g_cold, the gain at a hard blow there) and the full ramp
* at temp_c, whose waveforms the measures read. With `trimmed` 0 the trimmer is r_trim.
VPOS pos 0 {{v_pos}}
VNEG neg 0 {{v_neg}}
VMAG mag 0 PWL(0 0 {{t_ramp}} {{v_mag}})
EIN in 0 mag 0 -1
RDH in vhalf {{R-RESP-DIV-HI}}
RDL vhalf 0 {{R-RESP-DIV-LO}}
RIN in vg {{R-RESP-IN}}
RFB vg vsh {{R-RESP-FB}}
XA 0 vg pos neg vsh OPAx197
RPCW vhalf wip {{r_pot_cw}}
RPCCW wip vsh {{r_pot_ccw}}
RRESP wip tr {{R-RESP}}
RTRIM tr db {{r_trim}}
DA vg db DRESP
DB db vg DRESP
RRI vsh rs {{R-RESTORE-IN}}
RRF rs out {{R-RESTORE-FB}}
XB 0 rs pos neg out OPAx197
RLOAD out 0 {{r_load}}
.model DRESP D(IS={{is_d}} N={{n_d}} RS={{rs_d}} CJO=1.5p EG={{eg_d}})
.options rshunt=1e10
.control
if {{trimmed}} > 0
  let tr_lo = {{r_trim_end}}
  let tr_hi = {{TRIM-RESP}}
  alter rpcw = 1e-3
  alter rpccw = {{POT-RESP}}
  option temp={{t_comm}}
  let k = 0
  while k < 12
    let mid = (tr_lo + tr_hi) / 2
    alter rtrim = mid
    tran 1u {{t_hard_run}} 0 2u
    meas tran vset find v(out) at={{t_hard}}
    let g_set = -vset / {{v_hard}}
    if g_set > {{g_trim}}
      let tr_lo = mid
    else
      let tr_hi = mid
    end
    let k = k + 1
  end
  print g_set
  let r_set = mid
  print r_set
  alter rpcw = {{r_pot_cw}}
  alter rpccw = {{r_pot_ccw}}
end
option temp={{t_cold}}
tran 1u {{t_hard_run}} 0 2u
meas tran vcold find v(out) at={{t_hard}}
let g_cold = -vcold / {{v_hard}}
print g_cold
option temp={{temp_c}}
tran 1u {{t_ramp}} 0 2u
wrdata out.dat v(out)
wrdata wip.dat v(wip)
wrdata vsh.dat v(vsh)
wrdata idiode.dat (v(wip)-v(tr))/{{R-RESP}}
quit
.endc
.end
