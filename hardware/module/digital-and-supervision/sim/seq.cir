* The module's two 5 V rails at rack power-on and power-off, and what U-LVL-MOD's SYNC
* output does to the DAC8568's SYNC pin between them. As netlisted:
*  - the bus +12 V through PTC-POS12, D1 (1N5817, BEHAVIOURAL: power-entry/sim's fit),
*    FB1 (its DC resistance) and C1, with the module's analog load;
*  - DAC_AVDD: U-REG-DAC, TI's LM317L transient model, on R-REG-SET-LO / -HI with C-REG-ADJ
*    and C-REG-OUT, the DAC's own supply current as a resistance (power-entry/sim's deck);
*  - LOGIC_5V: U-REG-LOGIC, ADP7118 5.0 V, BEHAVIOURAL from its banked datasheet (no vendor
*    model): EN tied to VIN, on above UVLO, its internal soft start, a pass element that
*    sources only, with its dropout and current limit; C-LOGIC-IN / -OUT; the logic load;
*  - CS_MOD idle: R-PULL-CS to LOGIC_5V (no instrument on the cable), R-RX-CS and C-RX-CS
*    into U-RX-MOD, whose two gates and U-LVL-MOD gate 3 are one BEHAVIOURAL non-inverting
*    stage: output at LOGIC_5V through r_oh when the input is over half LOGIC_5V, with the
*    74AHCT125 output's clamp diodes to its VCC and ground (I_OK, VO > VCC);
*  - SYNC: R-PULL-SYNC to DAC_AVDD, and the DAC8568's SYNC pin as its pin capacitance and
*    an ESD diode to AVDD (BEHAVIOURAL: TI publishes none; the abs-max row "digital input
*    voltage -0.3 to AVDD + 0.3 V" is what it stands for).
* One cycle: the bus rises over t_rise, holds to t_off, falls over t_fall. uic: power-on.
VP12 bp12 0 PWL(0 0 1u 0 {{t_up_end}} {{v_bus}} {{t_off}} {{v_bus}} {{t_off_end}} 0)
RPTC1 bp12 bp12f {{r_ptc}}
D1 bp12f p12d D5817
RFB1 p12d p12 {{r_fb}}
C1 p12 0 {{C1}}
RLP p12 0 {{r_load_pos}}
* DAC_AVDD
XREG p12 adj avdd LM317L_TRANS
RSH avdd adj {{R-REG-SET-LO}}
RSL adj 0 {{R-REG-SET-HI}}
CADJ adj 0 {{C-REG-ADJ}}
CREG avdd 0 {{C-REG-OUT}}
RDAC avdd 0 {{r_dac}}
* LOGIC_5V: ADP7118, behavioural. ss charges while VIN is over UVLO (to 5 V in t_ss), and is
* discharged below it; the pass element sources current only, up to i_lim, towards
* min(ss, VIN - v_do)
CLIN p12 0 {{C-LOGIC-IN}}
Bss 0 ss I = (V(p12) > {{v_uvlo}}) ? ({{i_ss}} * (V(ss) < {{v_out_ldo}} ? 1 : 0)) : (-V(ss) * 1e-3)
Css ss 0 1n
Bldo p12 l5 I = max(0, min({{i_lim}}, {{gm_ldo}} * (min(V(ss), V(p12) - {{v_do}}) - V(l5))))
CLOUT l5 0 {{C-LOGIC-OUT}}
RL5 l5 0 {{r_logic}}
* CS_MOD idle, into the receiver
RPCS l5 csmod {{R-PULL-CS}}
RRX csmod csrc {{R-RX-CS}}
CRX csrc 0 {{C-RX-CS}}
* U-RX-MOD gates 5-6 and U-LVL-MOD gate 3, behavioural: SYNC's driver. U-LVL-MOD's VCC is
* LOGIC_5V as netlisted (k_avdd = 0); k_avdd = 1 is a WHAT-IF with it on DAC_AVDD. r_ser is
* a WHAT-IF series resistor between U-LVL-MOD's output and the pin (1 mohm: none)
Bvb vbuf 0 V = {{k_avdd}} * V(avdd) + (1 - {{k_avdd}}) * V(l5)
By yint 0 V = V(vbuf) * 0.5 * (1 + tanh(20 * (V(csrc) - 0.5 * V(l5))))
ROH yint ydrv {{r_oh}}
DOCH ydrv vbuf DCLAMP
DOCL 0 ydrv DCLAMP
RSER ydrv sync {{r_ser}}
* SYNC at the DAC
RPSYNC sync avdd {{R-PULL-SYNC}}
CPIN sync 0 {{c_pin}}
VIES sync syncd 0
DESD syncd avdd DESDM
.model D5817 D(Is={{d_is}} N={{d_n}} Rs={{d_rs}} Cjo=110p BV=20)
.model DCLAMP D(Is=1e-14 N=1 Rs=5)
.model DESDM D(Is={{is_esd}} N=1 Rs={{rs_esd}})
.options method=gear rshunt=1e10
.control
tran 5u {{t_end}} 0 10u uic
wrdata avdd.dat v(avdd)
wrdata l5.dat v(l5)
wrdata sync.dat v(sync)
wrdata over.dat v(sync)-v(avdd)
wrdata iesd.dat i(VIES)
wrdata p12.dat v(p12)
quit
.endc
.end
