* The module's two 5 V rails at rack power-on and power-off, and what U-LVL-MOD's three
* outputs - SYNC, SCLK_DAC and DIN - do to the DAC8568's pins between them. As netlisted:
*  - the bus +12 V through PTC-POS12, D1 (1N5817, BEHAVIOURAL: power-entry/sim's fit),
*    FB1 (its DC resistance) and C1, with the module's analog load;
*  - DAC_AVDD: U-REG-DAC, TI's LM317L transient model, on R-REG-SET-HI (OUT to ADJ) and
*    R-REG-SET-LO (ADJ to GND) with C-REG-ADJ and C-REG-OUT, the DAC's own supply current as
*    a resistance (power-entry/sim's deck);
*  - LOGIC_5V: U-REG-LOGIC, ADP7118 5.0 V, BEHAVIOURAL from its banked datasheet (no vendor
*    model): EN tied to VIN, on above UVLO, its internal soft start, a pass element that
*    sources only, with its dropout and current limit; C-LOGIC-IN / -OUT; the logic load;
*  - CS_MOD idle: R-PULL-CS to LOGIC_5V (no instrument on the cable), R-RX-CS and C-RX-CS
*    into U-RX-MOD (BEHAVIOURAL, on LOGIC_5V), driving U-LVL-MOD gate 3 (TI's SN74AHCT125
*    model), whose VCC is DAC_AVDD;
*  - SCLK_BUF and MOSI_BUF, U-RX-MOD's outputs into U-LVL-MOD gates 1 and 2, HELD HIGH at
*    LOGIC_5V throughout: the worst case, an instrument powered on its own (USB) holding
*    SCLK and MOSI high while the module's rails move. With nothing on the cable they are
*    pulled low and their outputs cannot be over anything;
*  - SYNC, SCLK_DAC and DIN at the DAC: R-PULL-SYNC to DAC_AVDD, R-PULL-SCLK-DAC and
*    R-PULL-DIN to ground, and each DAC pin as its pin capacitance and its power clamp to
*    AVDD, the I-V table of TI's IBIS model (TI publishes no SPICE model).
* One cycle: the bus rises over t_rise, holds to t_off, falls over t_fall. uic: power-on.
VP12 bp12 0 PWL(0 0 1u 0 {{t_up_end}} {{v_bus}} {{t_off}} {{v_bus}} {{t_off_end}} 0)
RPTC1 bp12 bp12f {{r_ptc}}
D1 bp12f p12d D5817
RFB1 p12d p12 {{r_fb}}
C1 p12 0 {{C1}}
RLP p12 0 {{r_load_pos}}
* DAC_AVDD
XREG p12 adj avdd LM317L_TRANS
RSH avdd adj {{R-REG-SET-HI}}
RSL adj 0 {{R-REG-SET-LO}}
CADJ adj 0 {{C-REG-ADJ}}
CREG avdd 0 {{C-REG-OUT}}
RDAC avdd 0 {{r_dac}}
* LOGIC_5V: ADP7118, behavioural. ss charges while VIN is over UVLO (to 5 V in t_ss), and is
* discharged below it; the pass element sources current only, up to i_lim, towards
* min(ss, VIN - v_do)
CLIN p12 0 {{C-LOGIC-IN}}
Bss 0 ss I = (V(p12) > {{v_uvlo}}) ? ({{i_ss}} * (V(ss) < {{v_out_ldo}} ? 1 : 0)) : (-V(ss) * 1e-3)
Css ss 0 1n
Bldo p12 l5 I = max(0, min({{i_lim}}, {{gm_ldo}} * (min(V(ss), V(p12) - {{v_do}}) - V(l5))))
CLOUT l5 0 {{C-LOGIC-OUT}}
RL5 l5 0 {{r_logic}}
* CS_MOD idle, into the receiver
RPCS l5 csmod {{R-PULL-CS}}
RRX csmod csrc {{R-RX-CS}}
CRX csrc 0 {{C-RX-CS}}
* U-RX-MOD gates 5-6, BEHAVIOURAL: CS_BUF at U-RX-MOD's supply when its input is high. Not
* TI's 74AHCT14 model: that is a generic AHC model whose thresholds are not this part's
* TTL ones (sims.yaml, models)
Bcs csbuf 0 V = V(l5) * 0.5 * (1 + tanh(20 * (V(csrc) - 0.5 * V(l5))))
* U-LVL-MOD gates 1-3: TI's SN74AHCT125 model, OE tied low, VCC on DAC_AVDD as netlisted
* (k_l5 = 0); k_l5 = 1 is a WHAT-IF putting it back on LOGIC_5V, where it was until 2026-10-01.
* TI's model has no output clamp to VCC; the datasheet's I_OK (VO > VCC) says the part has
* one, so it is added (DOCH)
* VCC is a source that follows the rail: TI's model will not converge on a VCC node tied to
* a rail through a resistance near 0 V, nor with the source's own current fed back onto it.
* What its outputs source into the two pull-downs is drawn from that rail explicitly; the
* buffer's own I_CC (20 uA max) is left out
Bvb vbuf 0 V = {{k_l5}} * V(l5) + (1 - {{k_l5}}) * V(avdd)
Bvbd avdd 0 I = (1 - {{k_l5}}) * (V(ysclk) / {{R-PULL-SCLK-DAC}} + V(ydin) / {{R-PULL-DIN}})
Bvbl l5 0 I = {{k_l5}} * (V(ysclk) / {{R-PULL-SCLK-DAC}} + V(ydin) / {{R-PULL-DIN}})
* SCLK_BUF and MOSI_BUF, U-RX-MOD gates 2 and 4 output high (BEHAVIOURAL, at its supply)
Bhi hibuf 0 V = V(l5)
XLVL3 ysync csbuf 0 vbuf 0 SN74AHCT125
XLVL1 ysclk hibuf 0 vbuf 0 SN74AHCT125
XLVL2 ydin hibuf 0 vbuf 0 SN74AHCT125
* the model's input-current term reads a global maxICC it never defines (TINA-TI supplies it):
* the 74AHCT125's Delta-I_CC, 1.5 mA per input at 3.4 V [ds SN74AHCT125.pdf p.4]
.param maxicc = 1.5m
DOCH3 ysync vbuf DCLAMP
DOCH1 ysclk vbuf DCLAMP
DOCH2 ydin vbuf DCLAMP
* SYNC at the DAC, pulled up to DAC_AVDD
RPSYNC ysync avdd {{R-PULL-SYNC}}
CPSYNC ysync 0 {{c_pin}}
VIES ysync syncd 0
XPSYNC syncd avdd DACPIN
* SCLK_DAC and DIN at the DAC, pulled down
RPSCLK ysclk 0 {{R-PULL-SCLK-DAC}}
CPSCLK ysclk 0 {{c_pin}}
VIESC ysclk sclkd 0
XPSCLK sclkd avdd DACPIN
RPDIN ydin 0 {{R-PULL-DIN}}
CPDIN ydin 0 {{c_pin}}
VIESD ydin dind 0
XPDIN dind avdd DACPIN
* each DAC8568 logic input is its pin capacitance (CP*, outside the current sense, so V* reads
* the clamp alone) and its POWER clamp from TI's IBIS model (input_5p0v): current into the pin
* against how far it is over AVDD, typ column, scaled by k_clamp for the min/max columns
.subckt DACPIN pin av
BESD pin av I = {{k_clamp}} * pwl(V(pin, av), -1, 0, 0.7025, 0, 0.745, 2.04961e-05, 0.77, 5.9866e-05, 0.83, 0.000175097, 0.9, 0.000345239, 0.996, 0.000645086, 1.0715, 0.000949736, 1.2065, 0.00161098, 1.359, 0.00241815, 1.5935, 0.00372301, 1.96, 0.00580486, 2.183, 0.0070934, 3.68, 0.0157434, 4.2245, 0.0188548, 5.0, 0.0236034, 10.0, 0.0472)
.ends
.model D5817 D(Is={{d_is}} N={{d_n}} Rs={{d_rs}} Cjo=110p BV=20)
.model DCLAMP D(Is=1e-14 N=1 Rs=5)
* gmin, itl4 and reltol: TI's 74AHCT125 model stalls while its VCC is under 1 V and
* its input is high (ngspice 42, "timestep too small", at the t_ss corners) without them
.options method=gear rshunt=1e10 gmin=1e-11 itl4=200 reltol=3e-3
.control
tran 5u {{t_end}} 0 10u uic
wrdata avdd.dat v(avdd)
wrdata l5.dat v(l5)
wrdata over.dat v(ysync)-v(avdd)
wrdata oversc.dat v(ysclk)-v(avdd)
wrdata overdin.dat v(ydin)-v(avdd)
wrdata iesd.dat i(VIES)
wrdata iesdsc.dat i(VIESC)
wrdata iesddin.dat i(VIESD)
wrdata p12.dat v(p12)
quit
.endc
.end
