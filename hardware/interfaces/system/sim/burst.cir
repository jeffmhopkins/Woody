* SCENARIO 2, a burst of DAC frames while breath is held: the whole system (system.lib) on
* the lumped umbilical, cold-started as led.cir is, the LED row blank, pitch held (jack
* 0 V). At t_b0 the ESP32 sends n_frames back-to-back DAC frames on SPI2 at f_clk, mode 1:
* SCLK runs while CS_MOD is low, MOSI changes on every SCLK rising edge (the most edges
* the link can carry), CS_MOD high for one clock period between frames (t_csh + t_csw,
* the firmware contract's minimums). U-LVL-MOD's three outputs repeat the pads' timeline
* t_chain later, into the DAC's pins. Each frame's end updates mod channel 1, between
* v_mod_code and v_mod_code + v_mod_step (the largest step its window allows); pitch and
* the other channels hold.
XC m1 m2 m3 m4 m5 m6 m7 m8 i1 i2 i3 i4 i5 i6 i7 i8 UMB_LUMPED
XS m1 m2 m3 m4 m5 m6 m7 m8 i1 i2 i3 i4 i5 i6 i7 i8
+ ledctl sclkctl mosictl csctl dsck ddin dsync dacp dacm1 dacm2 dacm3 dacm4 plug pplug hold SYS
VLED ledctl 0 0
* the pads: a free-running clock and data toggle, gated by the burst and by CS_MOD
VCK ck 0 PULSE(0 1 {{t_b0}} {{tr_drv}} {{tr_drv}} {{t_hi}} {{t_per}})
VDT dt 0 PULSE(0 1 {{t_b0}} {{tr_drv}} {{tr_drv}} {{t_dt_hi}} {{t_dt_per}})
VFR fr 0 PULSE(0 1 {{t_fr0}} {{tr_drv}} {{tr_drv}} {{t_fr_hi}} {{t_frame}})
VGT gt 0 PWL(0 0 {{t_gt0}} 0 {{t_gt0e}} 1 {{t_gt1}} 1 {{t_gt1e}} 0)
BSCK sclkctl 0 V = V(ck) * V(gt) * (1 - V(fr))
BMOS mosictl 0 V = V(dt) * V(gt)
BCSC csctl 0 V = 1 - V(gt) * (1 - V(fr))
* U-LVL-MOD's outputs: the same, t_chain later; SYNC is CS_MOD's copy
VCK2 ck2 0 PULSE(0 1 {{t_b0c}} {{t_lvl_edge}} {{t_lvl_edge}} {{t_hi}} {{t_per}})
VDT2 dt2 0 PULSE(0 1 {{t_b0c}} {{t_lvl_edge}} {{t_lvl_edge}} {{t_dt_hi}} {{t_dt_per}})
VFR2 fr2 0 PULSE(0 1 {{t_fr0c}} {{t_lvl_edge}} {{t_lvl_edge}} {{t_fr_hi}} {{t_frame}})
VGT2 gt2 0 PWL(0 0 {{t_gt0c}} 0 {{t_gt0ce}} 1 {{t_gt1c}} 1 {{t_gt1ce}} 0)
BDSK dsck 0 V = V(ck2) * V(gt2) * (1 - V(fr2))
BDDI ddin 0 V = V(dt2) * V(gt2)
BDSY dsync 0 V = 1 - V(gt2) * (1 - V(fr2))
* the DAC: mod channel 1 toggles at each frame's end, inside the burst
VUP up 0 PULSE(0 1 {{t_up0}} {{t_dac_edge}} {{t_dac_edge}} {{t_frame}} {{t_frame2}})
VGU gu 0 PWL(0 0 {{t_gt0c}} 0 {{t_gt0ce}} 1 {{t_gu1}} 1 {{t_gu1e}} 0)
BDM1 dacm1 0 V = {{v_mod_code}} * min(1, max(0, (time - {{t_sig0}}) / ({{t_sig1}} - {{t_sig0}}))) + {{v_mod_step}} * V(up) * V(gu)
VDP dacp 0 PWL(0 0 {{t_sig0}} 0 {{t_sig1}} {{v_dac0}})
VDM2 dacm2 0 PWL(0 0 {{t_sig0}} 0 {{t_sig1}} {{v_mod_code}})
VDM3 dacm3 0 PWL(0 0 {{t_sig0}} 0 {{t_sig1}} {{v_mod_code}})
VDM4 dacm4 0 PWL(0 0 {{t_sig0}} 0 {{t_sig1}} {{v_mod_code}})
VPLG plug 0 1
VPPL pplug 0 1
VHOLD hold 0 PWL(0 1 {{t_release}} 1 {{t_release_e}} 0)
.options method=gear rshunt=1e10
.control
tran {{t_max_step}} {{t_end_burst}} {{t_save0}} {{t_max_step}} uic
wrdata jp.dat v(xs.jp)
wrdata jb.dat v(xs.jb)
wrdata jm1.dat v(xs.jm1)
wrdata ina.dat v(xs.inaout) - v(xs.agnd)
wrdata agnd.dat v(xs.agnd)
wrdata srx.dat v(xs.srxi) - v(xs.dge)
quit
.endc
.end
