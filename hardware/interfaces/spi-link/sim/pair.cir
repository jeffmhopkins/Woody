* SCLK (IO35) and MOSI (IO36) to the module's 74AHCT125 1A and 2A, as netlisted: each
* pad (a source behind r_drv, its edge tr_drv), its R-SPI-SER, U-TVS-SPI's channel and
* the instrument's trace at J-UMB; then pair 4/5 of the cable, SCLK and MOSI TWISTED
* TOGETHER and returning on the other pairs - two coupled lines (ngspice CPL: the odd
* mode z_diff/2 from the cable's datasheet, the even mode 2 z_cm, swept); at the module
* the trace, the buffer's input and each line's R-SPI-PULL to DIG_GND.
* SCLK runs at f_clk from low (mode 1: idle low). MOSI is held at mosi0; with opp = 1 it
* changes to mosi1 on SCLK's second rising edge, the edge a mode-1 host launches data on.
* What-ifs, not the netlist: tvs_pad = 1 moves U-TVS-SPI to the pad side of R-SPI-SER;
* c_rx_extra adds a capacitor at each receiver input.
VS spad 0 PULSE(0 {{vdd}} {{t_r1}} {{tr_drv}} {{tr_drv}} {{t_hi}} {{t_per}})
RDS spad sa {{r_drv}}
RSS sa sj {{R-SPI-SER-SCLK}}
CTS sj 0 {{c_tvs_line}}
CTSP sa 0 {{c_tvs_pad}}
CIS sj 0 {{c_inst}}
VM mpad 0 PWL(0 {{mosi0}} {{t_r2}} {{mosi0}} {{t_r2_e}} {{mosi1}})
RDM mpad ma {{r_drv}}
RSM ma mj {{R-SPI-SER-MOSI}}
CTM mj 0 {{c_tvs_line}}
CTMP ma 0 {{c_tvs_pad}}
CIM mj 0 {{c_inst}}
P1 sj mj 0 srx mrx 0 PAIR
.model PAIR CPL length={{len}} R={{r_per_m}} 0 {{r_per_m}} L={{l_s}} {{l_m}} {{l_s}} G=0 0 0 C={{c_s}} {{c_m}} {{c_s}}
CMS srx 0 {{c_mod}}
CRS srx 0 {{c_rx}}
CXS srx 0 {{c_rx_extra}}
RPS srx 0 {{R-PULL-SCLK}}
CMM mrx 0 {{c_mod}}
CRM mrx 0 {{c_rx}}
CXM mrx 0 {{c_rx_extra}}
RPM mrx 0 {{R-PULL-MOSI}}
.control
tran 50p {{t_end}}
wrdata srx.dat v(srx)
wrdata mrx.dat v(mrx)
quit
.endc
.end
